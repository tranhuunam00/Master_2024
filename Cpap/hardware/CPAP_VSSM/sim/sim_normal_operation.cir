* SiPAP Rev C - normal operation (v2: real-adapter, UVLO, unpowered LM393, square-law Q1): hot-plug 12 V, rails up, ESP32 reset release, SFM3300 on,
* blower PWM 45 % (starts at 15 ms, time compressed), pressure 10 cmH2O on U2/U3, safety cutoff idle.
* Vendor models: LM393 = TI PSpice SLCJ016B (subckt LM2903B); Q3 2N7002 = Diodes Inc 2N7002.spice.txt
*   (subckt N7002, rev 2017-02-09). Both files: see models/README.md (URL + SHA-256).
* Behavioural, because the vendor publishes no model ngspice can read:
*   TPS54202 (TI SLVMBJ5C is an encrypted PSpice library) = regulated source, tSS 5 ms, UVLO rising
*   4.2 V (TI SLVSD26C p.5), efficiency 90 % / 85 % (assumed);
*   AO4407A / AO3401A (AOS product pages list no SPICE model, checked 2026-11-22) = switches at
*   datasheet VGS(th) and RDS(on), plus Ciss / body diode.
* MPXV5010 = NXP transfer function Vout = Vs*(0.09*P+0.04), 5 mA supply (NXP DS p.2).
* Loads (assumed): 3V3 120 mA (ESP32 + OLED), SFM3300 10 mA (<50 mW, Sensirion DS p.3),
*   blower I = (0.1 + 1.5*(VSR/3.3)^2) A at 12 V.
.INCLUDE "C:\Users\ADMIN\EDA Agent\workspace\spice\lm393.lib"
.INCLUDE "C:\Users\ADMIN\EDA Agent\workspace\spice\2N7002_Diodes.spice.txt"
.OPTIONS ITL4=200 RELTOL=0.003 METHOD=GEAR
.MODEL SWP SW(VT=2.0 VH=0.2 RON=0.017 ROFF=1E7)
.MODEL SWP2 SW(VT=0.9 VH=0.1 RON=0.05 ROFF=1E8)
.MODEL SWN SW(VT=1.8 VH=0.1 RON=2 ROFF=1E8)
.MODEL SWFG SW(VT=0.5 VH=0.1 RON=10 ROFF=1E8)
.MODEL SWEN SW(VT=2.0 VH=0.05 RON=1 ROFF=1E9)
.MODEL DBODY D(IS=1E-12 N=1.05 RS=0.01)
.MODEL DTVS D(IS=1E-12 BV=14.4 IBV=1M RS=0.1)
* ---- adapter + J1 + F1 MF-R400 (0.03 ohm typ, Bourns MF-R DS p.1)
VADP ADP 0 PWL(0 0 0.5M 0 1.5M 12 30M 12)
RADP ADP ADPC 0.05
CADP ADPC 0 470U
RCAB ADPC CAB 0.1
LCAB CAB VIN_RAW 1U
RF1 VIN_RAW VIN_FUSED 0.03
* ---- Q4 AO4407A reverse-polarity PMOS: S=VIN12V, D=VIN_FUSED, G=RPP_G (R26/R27 10k/10k)
DQ4 VIN_FUSED VIN12V DBODY
SQ4 VIN_FUSED VIN12V VIN12V RPP_G SWP
CQ4 VIN12V RPP_G 2.06N
R27 RPP_G VIN12V 10K
R26 RPP_G 0 10K
D2 0 VIN12V DTVS
C10 VIN12V 0 10U
C23 VIN12V 0 22U
C13 VIN12V 0 10U
C14 VIN12V 0 10U
C15 VIN12V 0 100N
C16 VIN12V 0 100N
* ---- U8 TPS54202 5V (behavioural): soft-start node SS5 0->1 V in 5 ms after VIN > 4.2 V
BSS5 0 SS5 I=0.2M*U(V(VIN12V)-4.2)*U(1-V(SS5))-20M*U(3.7-V(VIN12V))*U(V(SS5)-0.001)
CSS5 SS5 0 1U IC=0
RSS5 SS5 0 1G
B5 N5 0 V=MIN(5.08*V(SS5),MAX(V(VIN12V)-0.3,0))
V5S N5 N5B 0
R5O N5B 5V 0.02
C2 5V 0 22U
C18 5V 0 22U
BIN5 VIN12V 0 I=V(5V)*I(V5S)/(0.90*MAX(V(VIN12V),4))
* ---- U9 TPS54202 3V3 (behavioural)
BSS3 0 SS3 I=0.2M*U(V(VIN12V)-4.2)*U(1-V(SS3))-20M*U(3.7-V(VIN12V))*U(V(SS3)-0.001)
CSS3 SS3 0 1U IC=0
RSS3 SS3 0 1G
B3 N3 0 V=MIN(3.29*V(SS3),MAX(V(VIN12V)-0.3,0))
V3S N3 N3B 0
R3O N3B 3V3 0.02
C1 3V3 0 22U
C21 3V3 0 22U
C27 3V3 0 22U
C3 3V3 0 100N
RL3 3V3 0 27.5
BIN3 VIN12V 0 I=V(3V3)*I(V3S)/(0.85*MAX(V(VIN12V),4))
* ---- ESP32 EN reset delay R9/C5
R9 3V3 EN 10K
C5 EN 0 1U
* ---- pressure sensors at 10 cmH2O = 0.9807 kPa
BU2 PRI_SRC 0 V=V(5V)*(0.09*0.9807+0.04)
RU2O PRI_SRC PRESS_PRI_RAW 1
RU2S 5V 0 1K
C6 5V 0 1U
C7 5V 0 10N
C8 PRESS_PRI_RAW 0 470P
R1 PRESS_PRI_RAW PRESS_PRI_ADC 10K
R2 PRESS_PRI_ADC 0 20K
BU3 RED_SRC 0 V=V(5V)*(0.09*0.9807+0.04)
RU3O RED_SRC PRESS_RED_RAW 1
RU3S 5V 0 1K
C9 5V 0 1U
C11 5V 0 10N
C12 PRESS_RED_RAW 0 470P
R3 PRESS_RED_RAW PRESS_RED_ADC 10K
R4 PRESS_RED_ADC 0 20K
* ---- U7 LM393 hardware cutoff (unit A), threshold R10/R11, hysteresis R18
R10 5V COMP_REF 47K
R11 COMP_REF 0 10K
C4 5V 0 100N
XU7 PRESS_RED_ADC COMP_REF 5V 0 COMP_INT LM2903B
SEN COMP_INT COMP_OUT 5V 0 SWEN
RCI COMP_INT 0 1MEG
CPAR COMP_OUT 0 10P
R18 COMP_OUT PRESS_RED_ADC 1MEG
R17 GATE COMP_OUT 10K
R13 GATE VIN12V 10K
R15 COMP_OUT SAFETY_TRIP 1MEG
R16 SAFETY_TRIP 0 330K
* ---- Q1 AO4407A blower switch: S=VIN12V, D=BLOWER_V12, G=GATE
VIQ1 VIN12V Q1S 0
BQ1 Q1S BLOWER_V12 I=U(V(Q1S)-V(GATE)-2.0)*MIN(8*(V(Q1S)-V(GATE)-2.0)**2,(V(Q1S)-V(BLOWER_V12))/0.017)
CGS1 Q1S GATE 1.7N
CGD1 GATE BLOWER_V12 0.4N
* no slew capacitor (board as built)
DQ1 BLOWER_V12 VIN12V DBODY
C25 BLOWER_V12 0 220U
BBLW BLOWER_V12 0 I=V(BLOWER_V12)/12*(0.1+1.5*(V(BLOWER_VSR)/3.3)*(V(BLOWER_VSR)/3.3))
* ---- blower speed: IO10 PWM 20 kHz 45 % -> R28/C26 -> J2.3 VSR
VPWM IO10 0 PULSE(0 3.3 15M 20N 20N 22.48U 50U)
R28 IO10 BLOWER_VSR 1K
C26 BLOWER_VSR 0 1U
* ---- blower FG (open collector, 400 Hz assumed) -> R29 -> IO11, R12 pull-up
VFGC FGCTL 0 PULSE(0 1 16M 1U 1U 1.25M 2.5M)
SFG BLOWER_FG_IN 0 FGCTL 0 SWFG
R29 BLOWER_FG_IN BLOWER_FG 1K
R12 3V3 BLOWER_FG 10K
* ---- SFM3300 power switch: R24 pull-up SFM_EN, Q3 2N7002, Q2 AO3401A, R23
R24 3V3 SFM_EN 10K
XQ3 SFM_G SFM_EN 0 N7002
R23 5V SFM_G 100K
CQ2 5V SFM_G 645P
SQ2 5V SFM_5V 5V SFM_G SWP2
C24 SFM_5V 0 100N
RSFM SFM_5V 0 500
.TRAN 0.5U 25M 0 0.5U
.PLOT TRAN I(VIQ1) V(VIN_RAW) V(VIN12V) V(RPP_G) V(5V) V(3V3) V(EN) V(SFM_EN) V(SFM_G) V(SFM_5V) V(PRESS_PRI_RAW) V(PRESS_PRI_ADC) V(PRESS_RED_ADC) V(COMP_REF) V(COMP_OUT) V(GATE) V(BLOWER_V12) V(SAFETY_TRIP) V(IO10) V(BLOWER_VSR) V(BLOWER_FG)
.END
